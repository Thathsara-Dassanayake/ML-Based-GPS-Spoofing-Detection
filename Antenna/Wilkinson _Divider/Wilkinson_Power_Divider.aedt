# Ansys Electronics Desktop project, version 2018.0
materials:
  aluminum: permeability=1.000021 conductivity=38000000
  copper: permeability=0.999991 conductivity=58000000
  FR4_epoxy: permittivity=4.4 dielectric_loss_tangent=0.02
  pec: conductivity=1e+030
  TMM_3: permittivity=3.27 permeability=1 dielectric_loss_tangent=0.0016
  air: permittivity=1.0006 permeability=1.0000004
  vacuum: permittivity=1

design Wilkinson No Resistor (HFSS 3D Layout)
notes: Wilkinson Power Divider inside Cavity


Operates in the 3.5-4.5 GHz band.


For comparison with wilkinson
containing black box 
resistor.
options: Notes="Wilkinson Power Divider inside Cavity / Operates in the 3.5-4.5 GHz band. / For comparison with wilkinson / containing black box / resistor."
ports:
  Port1: Properties{Reference=Ground Impedance=50ohm Magnitude=0.001V Phase=0deg Renormalize="50ohm + 0i ohm" Deembed=0mm Type="Single Strip Gap Source" Ignore_Reference HFSS_Type=Gap Orientation=Vertical Layer_Alignment=Upper Horizontal_Extent_Factor=5 Vertical_Extent_Factor=3 PEC_Launch_Width=0mm} Type=EdgePort OrderId=1
  Port2: Properties{Reference=Ground Impedance=50ohm Magnitude=0.001V Phase=0deg Renormalize="50ohm + 0i ohm" Deembed=0mm Type="Single Strip Gap Source" Ignore_Reference HFSS_Type=Gap Orientation=Vertical Layer_Alignment=Upper Horizontal_Extent_Factor=5 Vertical_Extent_Factor=3 PEC_Launch_Width=0mm} Type=EdgePort OrderId=2
  Port3: Properties{Reference=Ground Impedance=50ohm Magnitude=0.001V Phase=0deg Renormalize="50ohm + 0i ohm" Deembed=0mm Type="Single Strip Gap Source" Ignore_Reference HFSS_Type=Gap Orientation=Vertical Layer_Alignment=Upper Horizontal_Extent_Factor=5 Vertical_Extent_Factor=3 PEC_Launch_Width=0mm} Type=EdgePort OrderId=3
setups:
  Setup 1: SolveSetupType=PEM PercentRefinementPerPass=25 MinNumberOfPasses=1 MinNumberOfConvergedPasses=1 Frequency=1.5GHz MeshSizeFactor=12 ViaNumSides=1 Style25DVia=Wirebond
    sweep Sweep 1: LINC 3.5GHz 4.5GHz 201; FastSweep SAbsError=0.005 ZoPercentError=1 PassivityTolerance=0.0001 MaxSolutions=250 InterpUseSMatrix InterpUsePortImpedance InterpUseFullBasis MagMinThreshold=0.01
reports:
  S-Parameters: dB(S(Port1,Port1)), dB(S(Port1,Port2)), dB(S(Port1,Port3)), dB(S(Port2,Port2)) vs F on Setup 1 : Sweep 1

design Wilkinson With Resistor (HFSS 3D Layout)
notes: Wilkinson Power Divider with black box resistor

Operates in the 3.5-4.5 GHz band.

For comparison with "wilk_c.adsn" divider with cavity model.
options: Notes='Wilkinson Power Divider with black box resistor / Operates in the 3.5-4.5 GHz band. / For comparison with "wilk_c.adsn" divider with cavity model.'
components:
  S7 = 100ohm_imported1(EMInstanceName=100ohm_imported1:7)
nets:
  InternalPort5: S7.0
  InternalPort6: S7.1
ports:
  Port1: Properties{Reference=Ground Impedance=50ohm Magnitude=0.001V Phase=0deg Renormalize="50ohm + 0i ohm" Deembed=0mm Type="Single Strip Gap Source" Ignore_Reference HFSS_Type=Gap Orientation=Vertical Layer_Alignment=Upper Horizontal_Extent_Factor=5 Vertical_Extent_Factor=3 PEC_Launch_Width=0mm} Type=EdgePort OrderId=1
  Port2: Properties{Reference=Ground Impedance=50ohm Magnitude=0.001V Phase=0deg Renormalize="50ohm + 0i ohm" Deembed=0mm Type="Single Strip Gap Source" Ignore_Reference HFSS_Type=Gap Orientation=Vertical Layer_Alignment=Upper Horizontal_Extent_Factor=5 Vertical_Extent_Factor=3 PEC_Launch_Width=0mm} Type=EdgePort OrderId=2
  Port3: Properties{Reference=Ground Impedance=50ohm Magnitude=0.001V Phase=0deg Renormalize="50ohm + 0i ohm" Deembed=0mm Type="Single Strip Gap Source" Ignore_Reference HFSS_Type=Gap Orientation=Vertical Layer_Alignment=Upper Horizontal_Extent_Factor=5 Vertical_Extent_Factor=3 PEC_Launch_Width=0mm} Type=EdgePort OrderId=3
setups:
  HFSS Setup 1: SolveSetupType=HFSS PercentRefinementPerPass=30 MinNumberOfPasses=1 MinNumberOfConvergedPasses=1 Frequency=10GHz MeshSizeFactor=1.5 ViaNumSides=6 ViaMaterial=copper Style25DVia=Mesh
    sweep Sweep 1: LIN 3.5GHz 4.5GHz 0.01GHz; FastSweep SAbsError=0.005 ZoPercentError=1 PassivityTolerance=0.0001 MaxSolutions=250 InterpUseSMatrix InterpUsePortImpedance InterpUseFullBasis MagMinThreshold=0.01
  Setup 1: SolveSetupType=PEM PercentRefinementPerPass=25 MinNumberOfPasses=1 MinNumberOfConvergedPasses=1 Frequency=4.5GHz MeshSizeFactor=12 ViaNumSides=1 Style25DVia=Wirebond
    sweep Sweep 1: LINC 3.5GHz 4.5GHz 201; FastSweep SAbsError=0.005 ZoPercentError=1 PassivityTolerance=0.0001 MaxSolutions=250 InterpUseSMatrix InterpUsePortImpedance InterpUseFullBasis MagMinThreshold=0.01
reports:
  S-Parameter_HFSS: dB(S(Port1,Port1)), dB(S(Port1,Port2)), dB(S(Port1,Port3)), dB(S(Port2,Port2)) vs F on HFSS Setup 1 : Sweep 1
  S-Parameter_PlanarEM: dB(S(Port1,Port1)), dB(S(Port1,Port2)), dB(S(Port1,Port3)), dB(S(Port2,Port2)) vs F on Setup 1 : Sweep 1
